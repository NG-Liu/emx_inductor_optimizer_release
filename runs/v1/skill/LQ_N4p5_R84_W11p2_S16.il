; Auto-generated by single_inductor_lq_surrogate

procedure(CDX_makeFdlLayout()
  let((libObj cv net term fig pinObj)
    libObj = ddGetObj("codex_fdl_bridge")
    unless(libObj
      libObj = ddCreateLib("codex_fdl_bridge" "/home/IC/EDA/codex_fdl_bridge")
    )
    techBindTechFile(libObj "smic13mmrf_1233")
    cv = dbOpenCellViewByType("codex_fdl_bridge" "LQ_N4p5_R84_W11p2_S16" "layout" "maskLayout" "w")
    unless(cv
      error("Failed to open codex_fdl_bridge/LQ_N4p5_R84_W11p2_S16/layout")
    )
    foreach(fig cv~>shapes dbDeleteObject(fig))
    foreach(term cv~>terminals dbDeleteObject(term))
    foreach(net cv~>nets dbDeleteObject(net))
    dbCreateRect(cv list("BORDER" "drawing") list(-283.3636:-227.6862 407.1677:213.93))
    dbCreatePolygon(cv list("M5" "drawing") list(-41.6389:-72.6741 0.2699:-86.0495 44.3989:-76.3747 78.6201:-45.0945 92.9267:0.2511 82.3396:47.8221 48.548:84.5676 0.2347:99.8042 -51.2473:88.3034 -90.5162:51.9997 -101.4128:16.8 -113.1371:16.8 -100.3263:58.1832 -56.643:98.5681 0.2347:111.3911 54.7569:94.3619 92.6189:53.1902 104.5125:0.2511 88.3963:-51.3324 49.7353:-86.6707 0.2699:-97.6338 -47.9101:-82.4292 -80.7238:-46.278 -90.4381:-1.1792 -79.4892:1.1792 -70.4085:-40.9783))
    dbCreatePolygon(cv list("M5" "drawing") list(-94.2664:-54.6742 -55.45:-96.4657 0.2077:-113.5593 58.1024:-100.2287 102.4161:-58.899 120.437:0.1964 106.1904:61.5318 62.3469:108.3671 0.1863:127.3147 -64.9622:112.1516 -114.3187:65.794 -129.0781:16.8 -140.7753:16.8 -124.1761:71.901 -70.4401:122.3721 0.1863:138.9046 68.4701:118.2146 116.4202:66.9925 132.0264:0.1964 112.2526:-65.04 63.5439:-110.4689 0.2077:-125.148 -61.611:-106.2898 -104.5181:-60.0941 -114.389:-16.8 -102.9016:-16.8))
    dbCreatePolygon(cv list("M5" "drawing") list(-118.1124:-68.3934 -69.2403:-120.2707 0.1688:-141.0702 71.8254:-124.0727 126.2232:-72.6859 147.9481:0.1613 130.0328:75.258 76.131:132.176 0.1544:154.8259 -78.6911:135.9925 -138.1292:79.5756 -156.6922:16.8 -168.3716:16.8 -148.0178:85.6314 -84.2233:146.1834 0.1544:166.4175 82.198:142.0579 140.2301:80.7784 159.5393:0.1613 136.0977:-78.7651 77.333:-134.2771 0.1688:-152.6611 -75.3327:-130.1371 -128.3244:-73.8869 -141.781:-16.8 -130.2741:-16.8))
    dbCreatePolygon(cv list("M5" "drawing") list(-141.952:-82.1247 -83.0197:-144.0826 0.1422:-168.5817 85.5587:-147.9113 150.0362:-86.4635 175.4595:0.1368 153.8704:88.9931 89.9068:155.9901 0.1318:182.3375 -92.4278:159.8292 -161.9442:93.3499 -184.277:16.8 -195.9439:16.8 -171.855:99.3691 -97.9986:169.9989 0.1318:193.93 95.9342:165.896 164.0448:94.5553 187.0519:0.1368 159.9369:-92.4996 91.1117:-158.0908 0.1422:-180.1738 -89.0653:-153.9775 -152.137:-87.6677 -169.2121:-16.8 -157.6916:-16.8))
    dbCreatePolygon(cv list("M5" "drawing") list(-165.788:-95.8629 -96.7927:-167.8984 0.1228:-196.0933 99.2982:-171.7465 173.8528:-100.2353 203.3896:1.5605 214.1459:-1.5605 183.7725:-106.2398 104.8842:-181.9078 0.1228:-207.6862 -102.8043:-177.8138 -175.9533:-101.4415 -196.6658:-16.8 -185.1354:-16.8))
    dbCreatePolygon(cv list("V4" "drawing") list(-42.7587:-74.4161 0.1735:-88.1181 45.3519:-78.2132 80.3659:-46.2084 94.9956:0.1614 84.1751:48.7807 49.6568:86.3165 0.1509:101.8733 -52.2108:90.1364 -92.268:53.1039 -103.5064:16.8 -111.0435:16.8 -98.5745:57.079 -55.6795:96.7351 0.1509:109.322 53.6482:92.6129 90.7833:52.2316 102.4436:0.1614 86.6505:-50.2185 48.7824:-84.8321 0.1735:-95.5652 -46.7902:-80.6872 -78.8818:-45.3316 -88.4829:0.7581 -81.4443:0.7581 -72.2505:-41.9247))
    dbCreatePolygon(cv list("V4" "drawing") list(-96.0971:-55.642 -56.5502:-98.22 0.1335:-115.6287 59.0741:-102.0573 104.1726:-59.9956 122.5065:0.1263 108.0172:62.5069 63.4403:110.1256 0.1197:129.3843 -65.9404:113.9767 -116.0789:66.8845 -131.1669:16.8 -138.6865:16.8 -122.4158:70.8105 -69.4619:120.547 0.1197:136.835 67.3767:116.4561 114.5935:66.0174 129.9568:0.1263 110.496:-63.9434 62.5722:-108.6403 0.1335:-123.0786 -60.5108:-104.5355 -102.6875:-59.1263 -112.3377:-16.8 -104.9529:-16.8))
    dbCreatePolygon(cv list("V4" "drawing") list(-119.936:-69.3744 -70.3282:-122.0326 0.1085:-143.14 72.8089:-125.8949 127.9865:-73.7715 150.0179:0.1037 131.8537:76.2438 77.2144:133.9406 0.0992:156.8958 -79.679:137.8123 -139.895:80.657 -158.7778:16.8 -166.286:16.8 -146.252:84.55 -83.2354:144.3636 0.0992:164.3476 81.1146:140.2933 138.4092:79.7926 157.4694:0.1037 134.3344:-77.6795 76.3495:-132.4549 0.1085:-150.5913 -74.2448:-128.3752 -126.5008:-72.9059 -139.7262:-16.8 -132.3289:-16.8))
    dbCreatePolygon(cv list("V4" "drawing") list(-143.7708:-83.1145 -84.0993:-145.8495 0.0914:-170.6517 86.5503:-149.7291 151.8042:-87.5413 177.5296:0.088 155.6872:89.9863 90.9832:157.759 0.0847:184.4075 -93.4226:161.6453 -163.714:94.4248 -186.3604:16.8 -193.8605:16.8 -170.0852:98.2943 -97.0038:168.1829 0.0847:191.8599 94.8579:164.1271 162.2279:93.562 184.9818:0.088 158.1689:-91.4217 90.1201:-156.273 0.0914:-178.1037 -87.9857:-152.2105 -150.3182:-86.6779 -167.1549:-16.8 -159.7488:-16.8))
    dbCreatePolygon(cv list("V4" "drawing") list(-167.6032:-96.859 -97.8662:-169.669 0.079:-198.1635 100.2957:-173.561 175.6242:-101.3075 205.3103:1.0032 212.2251:-1.0032 182.0011:-105.1676 103.8867:-180.0933 0.079:-205.616 -101.7308:-176.0432 -174.138:-100.4453 -194.6068:-16.8 -187.1944:-16.8))
    dbCreatePolygon(cv list("M5" "drawing") list(-79.3636:5.6 -259.3636:5.6 -259.3636:-5.6 -79.3636:-5.6))
    dbCreatePolygon(cv list("M5" "drawing") list(203.1677:-5.6 383.1677:-5.6 383.1677:5.6 203.1677:5.6))
    dbCreatePolygon(cv list("V4" "drawing") list(203.1677:-3.6 383.1677:-3.6 383.1677:3.6 203.1677:3.6))
    dbCreatePolygon(cv list("M4" "drawing") list(203.1677:-5.6 383.1677:-5.6 383.1677:5.6 203.1677:5.6))
    dbCreatePolygon(cv list("M4" "drawing") list(-70.408531:-40.978272 -41.638883:-72.674152 0.269851:-86.049435 44.398907:-76.374666 78.620124:-45.094564 92.926711:0.251076 82.339536:47.822065 48.548051:84.567535 0.234744:99.804125 -51.247358:88.303373 -90.516206:51.999754 -106.681644:0.220404 -94.266457:-54.674218 -55.44998:-96.465734 0.207715:-113.559242 58.102461:-100.228731 102.416057:-58.898967 120.437002:0.196407 106.190407:61.53186 62.346916:108.367041 0.18627:127.314716 -64.962246:112.151665 -114.318685:65.793982 -134.192471:0.17712 -118.112387:-68.393468 -69.240285:-120.270713 0.16883:-141.070258 71.825411:-124.072728 126.223154:-72.685929 147.948074:0.161282 130.032737:75.257983 76.131001:132.176053 0.154379:154.825914 -78.691098:135.992555 -138.129166:79.575573 -161.703772:0.148043 -141.95202:-82.124692 -83.0197:-144.082556 0.142206:-168.581647 85.55871:-147.911258 150.036188:-86.463436 175.459536:0.136815 153.870392:88.993105 89.906825:155.990134 0.131812:182.337437 -92.427832:159.829249 -161.944175:93.349902 -189.215348:0.127165 -165.787944:-95.862858 -96.792699:-167.898387 0.122834:-196.093268 99.298156:-171.746493 173.852853:-100.235244 203.389522:1.560512 214.145878:-1.560512 183.772547:-106.239756 104.884244:-181.907707 0.122834:-207.686132 -102.804301:-177.813813 -175.953256:-101.441542 -200.808052:0.127165 -171.855025:99.369098 -97.998568:169.998951 0.131812:193.929963 95.934175:165.896066 164.044808:94.555295 187.051864:0.136815 159.936812:-92.499564 91.11169:-158.090742 0.142206:-180.173753 -89.0653:-153.977444 -152.13698:-87.667708 -173.295628:0.148043 -148.017834:85.631427 -84.223302:146.183445 0.154379:166.417486 82.197999:142.057947 140.230063:80.778417 159.539326:0.161282 136.097646:-78.765071 77.332989:-134.277072 0.16883:-152.661142 -75.332715:-130.137087 -128.324413:-73.886932 -145.782929:0.17712 -124.176115:71.901018 -70.440154:122.372135 0.18627:138.904684 68.470084:118.214559 116.420193:66.99254 132.026398:0.196407 112.252543:-65.040033 63.543939:-110.468869 0.207715:-125.147958 -61.61102:-106.289866 -104.518143:-60.094182 -118.269556:0.220404 -100.326394:58.183246 -56.643042:98.568027 0.234744:111.391075 54.756949:94.361865 92.618864:53.190135 104.512489:0.251076 88.396276:-51.332436 49.735293:-86.670734 0.269851:-97.633765 -47.910117:-82.429248 -80.723869:-46.277928 -90.438043:-1.179183 -79.489157:1.179183))
    net = dbMakeNet(cv "P1")
    term = dbCreateTerm(net "P1" "inputOutput")
    fig = dbCreateRect(cv list("M5" "drawing") list(-263.3636:-4 -255.3636:4))
    dbAddFigToNet(fig net)
    pinObj = dbCreatePin(net fig "P1" term)
    when(pinObj
      dbReplaceProp(pinObj "accessDir" "string" "bidirectional")
    )
    dbCreateLabel(cv list("M5TXT" "drawing") -263.3636:0 "P1" "centerCenter" "R0" "roman" 8.0)
    net = dbMakeNet(cv "P2")
    term = dbCreateTerm(net "P2" "inputOutput")
    fig = dbCreateRect(cv list("M5" "drawing") list(379.1677:-4 387.1677:4))
    dbAddFigToNet(fig net)
    pinObj = dbCreatePin(net fig "P2" term)
    when(pinObj
      dbReplaceProp(pinObj "accessDir" "string" "bidirectional")
    )
    dbCreateLabel(cv list("M5TXT" "drawing") 387.1677:0 "P2" "centerCenter" "R0" "roman" 8.0)

    dbSave(cv)
    dbClose(cv)
    printf("CREATED=codex_fdl_bridge/LQ_N4p5_R84_W11p2_S16/layout\n")
    printf("SHAPES=15 PINS=2\n")
  )
)

CDX_makeFdlLayout()
exit()
